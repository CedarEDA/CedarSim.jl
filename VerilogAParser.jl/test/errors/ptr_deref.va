module ptr_deref(p, n);
    analog begin
        p=MTRLMOD->x;
    end
endmodule

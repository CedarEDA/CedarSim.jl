`define MPRco(nam,def,uni,lwr,upr,des) (*units=uni, desc=des*) parameter real nam=def from[lwr:upr) ;
module preproc_args_missing(p, n)
    `MPRco( DLCIG         , LINT           ,""                                      , "Source/drain overlap length for Igs")
endmodule

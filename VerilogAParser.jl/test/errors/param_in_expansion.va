`define MPRnb(nam,def,uni,        des) (* units=uni, desc=des *) parameter real    nam=def;
module param_in_expansion(p, n)
    `MPRnb( TBGASUB       , 7.02e-4eV/K    ,"eV/K"                                  , "First parameter of band-gap change due to temperature")
end

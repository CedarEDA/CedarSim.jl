module vtemexp(p, n);
    analog function integer truncInt;
        real x;

        truncInt = x > 0.0 ? floor(x) : ceil(x);
    end

    inout p, n;
    electrical p, n;

    analog begin
        I(p,n) <+ 0;
    end
endmodule

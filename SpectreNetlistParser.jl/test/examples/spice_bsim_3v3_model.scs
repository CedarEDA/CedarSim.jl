//Berkeley Spice Compatibility
//Lmin= .35 Lmax= 20 Wmin= .6 Wmax= 20
simulator lang=spectre
model nch bsim3v3
+version=3.1
+type=n
+tnom=27.0
+nch=2.498E+17  tox=9E-09  xj=1.00000E-07
+lint=9.36e-8  wint=1.47e-7
+vth0=.6322  k1=.756  k2=-3.83e-2  k3=-2.612
+dvt0=2.812  dvt1=0.462  dvt2=-9.17e-2
+nlx=3.52291E-08  w0= 1.163e-6  k3b= 2.233
+vsat=86301.58  ua=6.47e-9  ub=4.23e-18  uc=-4.706281e-11
+rdsw=650  u0=388.3203  wr=1
+a0=.3496967  ags=.1
+b0=0.546  b1= 1
+dwg=-6.0e-09  dwb=-3.56e-09  prwb=-.213
+keta=-3.605872e-02  a1=2.778747e-02  a2=.9
+voff=-6.735529e-02  nfactor=1.139926  cit=1.622527e-04
+cdsc=-2.147181e-05  cdscb= 0
+dvt0w=0  dvt1w=0  dvt2w=0
+cdscd=0  prwg=0
+eta0=1.0281729e-02  etab=-5.042203e-03
+dsub=.31871233
+pclm=1.114846  pdiblc1=2.45357e-03  pdiblc2=6.406289e-03
+drout=.31871233  pscbe1=5000000  pscbe2=5e-09 pdiblcb=-.234
+pvag=0  delta=0.01
+wl=0  ww=-1.420242e-09  wwl =  0
+wln=0  wwn=.2613948  ll=1.300902e-10
+lw=0  lwl=0  lln=.316394  lwn=0
+kt1=-.3  kt2=-.051
+at=22400
+ute=-1.48
+ua1=3.31e-10  ub1=2.61e-19  uc1=-3.42e-10
+kt1l=0  prt=764.3
